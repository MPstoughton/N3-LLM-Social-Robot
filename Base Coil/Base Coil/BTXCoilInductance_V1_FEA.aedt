# Ansys Electronics Desktop project, version 2025.1
materials:
  vacuum: permittivity=1
  copper: permeability=0.999991 conductivity=58000000
  air: permittivity=1.0006 permeability=1.0000004

design Maxwell3DDesign1 (Maxwell 3D, Magnetostatic, model units mm)
geometry:
  BaseCoil_copper [copper] = imported_body(C:\Users\maxim\N3 LLM Social Robot\Base Coil\Base Coil\Base Coil.step.SLDPRT)
  BaseCoil_copper.rotate(axis=Z, angle=-45deg)
  Box1 [air] = box(corner=(61.254076mm, -150mm, -50mm), size=((-4.7540764008565-200) mm, 300mm, 100mm))
boundaries and excitations:
  Term1: Current Faces=BaseCoil_copper.face(at (61.2541, -7.07107, 0.755)) Current=1A IsSolid=true Point_out_of_terminal=false
  Term2: Current Faces=BaseCoil_copper.face(at (61.2541, -1.99107, 0.755)) Current=1A IsSolid=true Point_out_of_terminal=true
parameters:
  Matrix1: Matrix Term1: NumberOfTurns=1
mesh:
  initial mesh: GlobalCurvilinear{Apply}
setups:
  Setup1: Magnetostatic MaximumPasses=10 MinimumPasses=2 MinimumConvergedPasses=1 PercentRefinement=30 PercentError=1 NonLinearResidual=0.001
